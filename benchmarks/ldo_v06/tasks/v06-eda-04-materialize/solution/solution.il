; EvoLDO IC618 reference: every object is created under the invocation scratch.
procedure(evoldoWriteResult(key value extra)
  let((p)
    p=outfile("evoldo_result.json" "w")
    unless(p error("cannot create terminal result"))
    fprintf(p "{\"status\":\"OK\",\"%s\":\"%s\"%s}\n" key value extra)
    close(p)))

procedure(evoldoScratchCv(mode)
  let((lib path cv)
    lib="EVOLDO_V06_SCRATCH"
    path=simplifyFilename(strcat(getWorkingDir() "/oa_lib"))
    unless(ddGetObj(lib) ddCreateLib(lib path))
    cv=dbOpenCellViewByType(lib "fixture" "schematic" "schematic" mode)
    unless(cv error("cannot open isolated scratch cellview"))
    cv))

procedure(evoldoTermPoint(inst termName)
  let((term pin fig bb)
    term=car(setof(x inst~>master~>terminals x~>name==termName))
    unless(term error("missing terminal %s" termName))
    pin=car(term~>pins) fig=car(pin~>figs)
    bb=dbTransformBBox(fig~>bBox inst~>transform)
    list((xCoord(car(bb))+xCoord(cadr(bb)))/2.0
         (yCoord(car(bb))+yCoord(cadr(bb)))/2.0)))

procedure(evoldoCreateFixture()
  let((cv master r0 p q)
    cv=evoldoScratchCv("w")
    master=dbOpenCellViewByType("analogLib" "res" "symbol" nil "r")
    unless(master error("analogLib/res unavailable"))
    r0=dbCreateInst(cv master "R0" 0:0 "R0")
    unless(r0 error("cannot create R0"))
    dbReplaceProp(r0 "evoldoSizing" "string" "40u")
    p=evoldoTermPoint(r0 "PLUS") q=list(xCoord(p)-1.0 yCoord(p))
    schCreateWire(cv "route" "full" list(p q) 0 0 0 nil nil)
    dbCreateLabel(cv list("wire" "label") q "VIN" "lowerLeft" "R0" "stick" 0.0625)
    evoldoFixtureCheck=schCheck(cv) dbSave(cv) dbClose(cv)
    t))

procedure(evoldoMain()
  let((cv master r1 p q chk named shapeCount)
    evoldoCreateFixture()
    cv=evoldoScratchCv("a") master=dbOpenCellViewByType("analogLib" "res" "symbol" nil "r")
    r1=dbCreateInst(cv master "R1" 4:0 "R0")
    p=evoldoTermPoint(r1 "PLUS") q=list(xCoord(p)-1.0 yCoord(p))
    schCreateWire(cv "route" "full" list(p q) 0 0 0 nil nil)
    dbCreateLabel(cv list("wire" "label") q "VOUT" "lowerLeft" "R0" "stick" 0.0625)
    chk=schCheck(cv) dbSave(cv) dbClose(cv)
    cv=evoldoScratchCv("r") named=dbFindNetByName(cv "VOUT") shapeCount=length(cv~>shapes) dbClose(cv)
    unless(chk && car(chk)==0 && named && shapeCount>0 error("materialization did not persist"))
    evoldoWriteResult("materialization_result" "net_and_wire_figures_persist" ",\"reopen_verified\":true")))
evoldoMain()
exit()
