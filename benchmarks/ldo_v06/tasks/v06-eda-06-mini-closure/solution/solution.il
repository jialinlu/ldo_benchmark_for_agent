; EvoLDO IC618 reference: every object is created under the invocation scratch.
procedure(evoldoWriteResult(key value extra)
  let((p)
    p=outfile("evoldo_result.json" "w")
    unless(p error("cannot create terminal result"))
    fprintf(p "{\"status\":\"OK\",\"%s\":\"%s\"%s}\n" key value extra)
    close(p)))

procedure(evoldoScratchCv(mode)
  let((lib path cv)
    lib="EVOLDO_V06_SCRATCH"
    path=simplifyFilename(strcat(getWorkingDir() "/oa_lib"))
    unless(ddGetObj(lib) ddCreateLib(lib path))
    cv=dbOpenCellViewByType(lib "fixture" "schematic" "schematic" mode)
    unless(cv error("cannot open isolated scratch cellview"))
    cv))

procedure(evoldoTermPoint(inst termName)
  let((term pin fig bb)
    term=car(setof(x inst~>master~>terminals x~>name==termName))
    unless(term error("missing terminal %s" termName))
    pin=car(term~>pins) fig=car(pin~>figs)
    bb=dbTransformBBox(fig~>bBox inst~>transform)
    list((xCoord(car(bb))+xCoord(cadr(bb)))/2.0
         (yCoord(car(bb))+yCoord(cadr(bb)))/2.0)))

procedure(evoldoCreateFixture()
  let((cv master r0 p q)
    cv=evoldoScratchCv("w")
    master=dbOpenCellViewByType("analogLib" "res" "symbol" nil "r")
    unless(master error("analogLib/res unavailable"))
    r0=dbCreateInst(cv master "R0" 0:0 "R0")
    unless(r0 error("cannot create R0"))
    dbReplaceProp(r0 "evoldoSizing" "string" "40u")
    p=evoldoTermPoint(r0 "PLUS") q=list(xCoord(p)-1.0 yCoord(p))
    schCreateWire(cv "route" "full" list(p q) 0 0 0 nil nil)
    dbCreateLabel(cv list("wire" "label") q "VIN" "lowerLeft" "R0" "stick" 0.0625)
    evoldoFixtureCheck=schCheck(cv) dbSave(cv) dbClose(cv)
    t))

procedure(evoldoMain()
  let((cv inst value p rc)
    evoldoCreateFixture()
    cv=evoldoScratchCv("a") inst=car(cv~>instances)
    dbReplaceProp(inst "evoldoSizing" "string" "80u") dbSave(cv) dbClose(cv)
    cv=evoldoScratchCv("r") value=car(cv~>instances)~>evoldoSizing dbClose(cv)
    unless(value=="80u" error("candidate readback failed"))
    p=outfile("gate.scs" "w") fprintf(p "simulator lang=spectre\nV0 (vdd 0) vsource dc=1.8\nR1 (vdd out) resistor r=600\nR2 (out 0) resistor r=1.2k\ndcOp dc\n") close(p)
    rc=system("/opt/eda/cadence/SPECTRE181/bin/spectre gate.scs +log gate.log > gate.stdout 2>&1")
    unless(rc==0 error("fresh closure gate failed"))
    evoldoWriteResult("closure_result" "change_accepted_after_fresh_gate" ",\"reopen_verified\":true")))
evoldoMain()
exit()
